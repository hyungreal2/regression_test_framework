procedure(Validate(ddid expectedState expectedVersion)
	prog((speclist result)
	result=t
	speclist=gdmCreateSpecList()
	gdmAddSpecToSpecList(gdmCreateSpecFromDDID(ddid) speclist)
	rexCompile("(\\.cdslck.*)|(\\.oacache.*)|(\\.tmp\\.[a-z])")
	foreach(spec gdmstatus(speclist 6)
		tokens=parseString(car(spec))
		unless(or(rexMatchp("\\.cdslck.*" car(tokens)) rexMatchp("\\.oacache.*" car(tokens)) rexMatchp("\\.tmp\\.[a-z]" car(tokens)) rexMatchp("data.dm\\.*" car(tokens)) rexMatchp("thumbnail_128x128.png\\.*" car(tokens)))
			if(strcmp(cadr(tokens) expectedState) != 0 then
				printf("ERROR: %s expected %s but got %s\n" car(tokens)
			       		expectedState cadr(tokens))
				result=nil
			)
		)
	)
	gdmResetSpecList(speclist)
	foreach(spec gdmstatus(speclist 10)
		tokens=parseString(car(spec))
		unless(or(rexMatchp("\\.cdslck.*" car(tokens)) rexMatchp("\\.oacache.*" car(tokens)) rexMatchp("\\.tmp\\.[a-z]" car(tokens)) rexMatchp("data.dm\\.*" car(tokens)) rexMatchp("thumbnail_128x128.png\\.*" car(tokens)))
			if(strcmp(cadr(tokens) expectedVersion) != 0 then
				printf("ERROR: %s expected version %s but got %s\n" car(tokens)
			       	       expectedVersion cadr(tokens))
				result=nil
			)
		)
	)
	return(result)
	)
)

procedure(Validate_hier(ddid expectedState) ; expectedState={"CI" "CO"}
	prog(( result libName cellName hierCnt )
		result=t
		libName=ddid->lib->name
		cellName=ddid->cell->name

		mgHierParse( libName cellName "schematic" "./text.txt")

		case(expectedState
			("CI"
				ICM_runP4("-x text.txt files 2>/dev/null | sed 's/#.*//'> ./hier.txt")
				ICM_runP4("-x hier.txt opened 2>/dev/null | wc -l")
				if(ICM_IPCBuffer != "0\n" then
					printf("ERROR: %Y/%Y/%Y expected hier opened 0 but got %Y\n"
									ddid->lib->name ddid->cell->name ddid->name ICM_IPCBuffer)
					result=nil
				)
			)
			("CO"
				ICM_runP4("-x text.txt files 2>/dev/null | sed 's/#.*//'> ./hier.txt")
				ICM_runCmd("cat hier.txt | wc -l")
				hierCnt = ICM_IPCBuffer
				ICM_runP4("-x hier.txt opened 2>/dev/null | wc -l")
				if(ICM_IPCBuffer != hierCnt then
					printf("ERROR: %Y/%Y/%Y expected hier opened %Y but got %Y\n"
									ddid->lib->name ddid->cell->name ddid->name substring(hierCnt 1 strlen(hierCnt)-1) ICM_IPCBuffer)
					result=nil
				)
			)
		)
		return(result)
	)
)

procedure(Validate_hierAll(ddid openedPreCnt) ; expectedState={"CI" "CO"}
	prog(( result libName cellName hierCnt )
		result=t
		libName=ddid->lib->name
		cellName=ddid->cell->name

		mgHierParse( libName cellName "schematic" "./text.txt")

		ICM_runP4("-x text.txt files 2>/dev/null | sed 's/#.*//' | wc -l ")
		hierCount=atoi(car(last(parseString(ICM_IPCBuffer "\n"))))

		ICM_runP4("opened ... | wc -l")
		openedPostCnt=atoi(car(last(parseString(ICM_IPCBuffer "\n"))))
		if(openedPreCnt - hierCount != openedPostCnt then
			printf("ERROR: %Y/%Y/%Y expected opened %Y in lib but got %Y\n"
									ddid->lib->name ddid->cell->name ddid->name openedPostCnt openedPreCnt-hierCount)
			result=nil
		)
		return(result)
	)
)

procedure(Validate_refCount(ddid expectedCount)
	prog((result refCount)
		result=t
		refCount=_ddBatchRefCount(ddid)
		if(expectedCount != refCount then
			printf("ERROR: %Y/%Y/%Y expected refCount %Y but got %Y\n"
			       	ddid->lib->name ddid->cell->name ddid->name expectedCount refCount)
			result=nil
		)
		return(list(result refCount))
	)
)
